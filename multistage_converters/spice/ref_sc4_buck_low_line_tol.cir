* converter deck, bench.py (v90 48V->3V)
* corner=low_line_tol duty=0.2863
* device map (netlist -> deck): Sa0->S1, Sb0->S2, Sa1->S3, Sb1->S4, C0->C1, C1->C2, Sa2->S5, Sb2->S6, Sa3->S7, Sb3->S8, C2->C3, C3->C4, Sa4->S9, Sb4->S10, L0->L1
* nodes: IN->VIN, OUT->VOUT, 0->0, X->nX
Vin VIN 0 DC 43.2
Vpa PA 0 PULSE(0 1 0 1n 1n 5.726e-07 2e-06)
Vpb PB 0 PULSE(1 0 0 1n 1n 5.726e-07 2e-06)
.model SWMOD SW(ron=0.005 roff=1000000.0 vt=0.5 vh=0.01)
S1 VIN nn1 PA 0 SWMOD
S2 nn1 nn3 PB 0 SWMOD
S3 nn2 nn3 PA 0 SWMOD
S4 nn2 0 PB 0 SWMOD
C1 nn1 cx1 3.76e-05
RC1 cx1 nn2 0.002
C2 nn3 cx2 3.76e-05
RC2 cx2 0 0.002
S5 nn3 nn5 PA 0 SWMOD
S6 nn5 nn7 PB 0 SWMOD
S7 nn6 nn7 PA 0 SWMOD
S8 nn6 0 PB 0 SWMOD
C3 nn5 cx3 3.76e-05
RC3 cx3 nn6 0.002
C4 nn7 cx4 3.76e-05
RC4 cx4 0 0.002
S9 nn7 nn8 PA 0 SWMOD
S10 nn8 0 PB 0 SWMOD
L1 nn8 lx1 1.76e-06
RL1 lx1 VOUT 0.002
Rout VOUT 0 0.3
Cout VOUT co_x 3.76e-05
RCo co_x 0 0.002
.options gmin=1e-12 reltol=1e-3 abstol=1e-9 vntol=1e-6 itl1=200 itl4=100
.control
set noaskquit
save all @c1[i] @c2[i] @c3[i] @c4[i] @cout[i]
tran 1e-08 0.004 0.00396 1e-08
let pout = v(VOUT)*v(VOUT)/0.3
let pin = -43.2*i(vin)
meas tran vout_avg AVG v(VOUT) from=0.00396 to=0.004
meas tran pout_avg AVG pout from=0.00396 to=0.004
meas tran pin_avg  AVG pin  from=0.00396 to=0.004
meas tran vout_max MAX v(VOUT) from=0.00396 to=0.004
meas tran vout_min MIN v(VOUT) from=0.00396 to=0.004
let vs1 = v(VIN)-v(nn1)
meas tran vs1_max MAX vs1 from=0.00396 to=0.004
meas tran vs1_min MIN vs1 from=0.00396 to=0.004
let vs2 = v(nn1)-v(nn3)
meas tran vs2_max MAX vs2 from=0.00396 to=0.004
meas tran vs2_min MIN vs2 from=0.00396 to=0.004
let vs3 = v(nn2)-v(nn3)
meas tran vs3_max MAX vs3 from=0.00396 to=0.004
meas tran vs3_min MIN vs3 from=0.00396 to=0.004
let vs4 = v(nn2)
meas tran vs4_max MAX vs4 from=0.00396 to=0.004
meas tran vs4_min MIN vs4 from=0.00396 to=0.004
let vs5 = v(nn3)-v(nn5)
meas tran vs5_max MAX vs5 from=0.00396 to=0.004
meas tran vs5_min MIN vs5 from=0.00396 to=0.004
let vs6 = v(nn5)-v(nn7)
meas tran vs6_max MAX vs6 from=0.00396 to=0.004
meas tran vs6_min MIN vs6 from=0.00396 to=0.004
let vs7 = v(nn6)-v(nn7)
meas tran vs7_max MAX vs7 from=0.00396 to=0.004
meas tran vs7_min MIN vs7 from=0.00396 to=0.004
let vs8 = v(nn6)
meas tran vs8_max MAX vs8 from=0.00396 to=0.004
meas tran vs8_min MIN vs8 from=0.00396 to=0.004
let vs9 = v(nn7)-v(nn8)
meas tran vs9_max MAX vs9 from=0.00396 to=0.004
meas tran vs9_min MIN vs9 from=0.00396 to=0.004
let vs10 = v(nn8)
meas tran vs10_max MAX vs10 from=0.00396 to=0.004
meas tran vs10_min MIN vs10 from=0.00396 to=0.004
* --- capacitor current probes ---
meas tran ic_c0_rms RMS @c1[i] from=0.00396 to=0.004
meas tran ic_c0_max MAX @c1[i] from=0.00396 to=0.004
meas tran ic_c0_min MIN @c1[i] from=0.00396 to=0.004
meas tran ic_c1_rms RMS @c2[i] from=0.00396 to=0.004
meas tran ic_c1_max MAX @c2[i] from=0.00396 to=0.004
meas tran ic_c1_min MIN @c2[i] from=0.00396 to=0.004
meas tran ic_c2_rms RMS @c3[i] from=0.00396 to=0.004
meas tran ic_c2_max MAX @c3[i] from=0.00396 to=0.004
meas tran ic_c2_min MIN @c3[i] from=0.00396 to=0.004
meas tran ic_c3_rms RMS @c4[i] from=0.00396 to=0.004
meas tran ic_c3_max MAX @c4[i] from=0.00396 to=0.004
meas tran ic_c3_min MIN @c4[i] from=0.00396 to=0.004
meas tran ic_cout_rms RMS @cout[i] from=0.00396 to=0.004
meas tran ic_cout_max MAX @cout[i] from=0.00396 to=0.004
meas tran ic_cout_min MIN @cout[i] from=0.00396 to=0.004
quit
.endc
.end
