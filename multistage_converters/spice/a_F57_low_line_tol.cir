* converter deck, bench.py (v90 48V->3V)
* corner=low_line_tol duty=0.4560
* device map (netlist -> deck): Sa0s1->S1, Sb0s1->S2, Sa1s1->S3, Sb1s1->S4, C0s1->C1, C1s1->C2, Sb0s2->S5, C0s2->C3, L0s2->L1, Sa0s2->S6, Sb1s2->S7, Sa0s3->S8, Sb0s3->S9, L0s3->L2, Cbus2->C4
* nodes: IN->VIN, OUT->VOUT, 0->0, X->nX
Vin VIN 0 DC 43.2
Vpa PA 0 PULSE(0 1 0 1n 1n 9.12e-07 2e-06)
Vpb PB 0 PULSE(1 0 0 1n 1n 9.12e-07 2e-06)
.model SWMOD SW(ron=0.005 roff=1000000.0 vt=0.5 vh=0.01)
S1 VIN ns1n1 PA 0 SWMOD
S2 ns1n1 nBUS1 PB 0 SWMOD
S3 ns1n2 nBUS1 PA 0 SWMOD
S4 ns1n2 0 PB 0 SWMOD
C1 ns1n1 cx1 3.76e-05
RC1 cx1 ns1n2 0.002
C2 nBUS1 cx2 3.76e-05
RC2 cx2 0 0.002
S5 nBUS2 ns2n8 PB 0 SWMOD
C3 ns2n8 cx3 3.76e-05
RC3 cx3 ns2n9 0.002
L1 nBUS2 lx1 1.76e-06
RL1 lx1 ns2n9 0.004
S6 nBUS1 ns2n8 PA 0 SWMOD
S7 0 ns2n9 PB 0 SWMOD
S8 nBUS2 ns3n1 PA 0 SWMOD
S9 ns3n1 0 PB 0 SWMOD
L2 ns3n1 lx2 1.76e-06
RL2 lx2 VOUT 0.004
C4 nBUS2 cx4 3.76e-05
RC4 cx4 0 0.002
Rout VOUT 0 0.3
Cout VOUT co_x 3.76e-05
RCo co_x 0 0.002
.options gmin=1e-12 reltol=1e-3 abstol=1e-9 vntol=1e-6 itl1=200 itl4=100
.control
set noaskquit
save all @c1[i] @c2[i] @c3[i] @c4[i] @cout[i]
tran 1e-08 0.004 0.00396 1e-08
let pout = v(VOUT)*v(VOUT)/0.3
let pin = -43.2*i(vin)
meas tran vout_avg AVG v(VOUT) from=0.00396 to=0.004
meas tran pout_avg AVG pout from=0.00396 to=0.004
meas tran pin_avg  AVG pin  from=0.00396 to=0.004
meas tran vout_max MAX v(VOUT) from=0.00396 to=0.004
meas tran vout_min MIN v(VOUT) from=0.00396 to=0.004
let vs1 = v(VIN)-v(ns1n1)
meas tran vs1_max MAX vs1 from=0.00396 to=0.004
meas tran vs1_min MIN vs1 from=0.00396 to=0.004
let vs2 = v(ns1n1)-v(nBUS1)
meas tran vs2_max MAX vs2 from=0.00396 to=0.004
meas tran vs2_min MIN vs2 from=0.00396 to=0.004
let vs3 = v(ns1n2)-v(nBUS1)
meas tran vs3_max MAX vs3 from=0.00396 to=0.004
meas tran vs3_min MIN vs3 from=0.00396 to=0.004
let vs4 = v(ns1n2)
meas tran vs4_max MAX vs4 from=0.00396 to=0.004
meas tran vs4_min MIN vs4 from=0.00396 to=0.004
let vs5 = v(nBUS2)-v(ns2n8)
meas tran vs5_max MAX vs5 from=0.00396 to=0.004
meas tran vs5_min MIN vs5 from=0.00396 to=0.004
let vs6 = v(nBUS1)-v(ns2n8)
meas tran vs6_max MAX vs6 from=0.00396 to=0.004
meas tran vs6_min MIN vs6 from=0.00396 to=0.004
let vs7 = -v(ns2n9)
meas tran vs7_max MAX vs7 from=0.00396 to=0.004
meas tran vs7_min MIN vs7 from=0.00396 to=0.004
let vs8 = v(nBUS2)-v(ns3n1)
meas tran vs8_max MAX vs8 from=0.00396 to=0.004
meas tran vs8_min MIN vs8 from=0.00396 to=0.004
let vs9 = v(ns3n1)
meas tran vs9_max MAX vs9 from=0.00396 to=0.004
meas tran vs9_min MIN vs9 from=0.00396 to=0.004
* --- capacitor current probes ---
meas tran ic_c0s1_rms RMS @c1[i] from=0.00396 to=0.004
meas tran ic_c0s1_max MAX @c1[i] from=0.00396 to=0.004
meas tran ic_c0s1_min MIN @c1[i] from=0.00396 to=0.004
meas tran ic_c1s1_rms RMS @c2[i] from=0.00396 to=0.004
meas tran ic_c1s1_max MAX @c2[i] from=0.00396 to=0.004
meas tran ic_c1s1_min MIN @c2[i] from=0.00396 to=0.004
meas tran ic_c0s2_rms RMS @c3[i] from=0.00396 to=0.004
meas tran ic_c0s2_max MAX @c3[i] from=0.00396 to=0.004
meas tran ic_c0s2_min MIN @c3[i] from=0.00396 to=0.004
meas tran ic_cbus2_rms RMS @c4[i] from=0.00396 to=0.004
meas tran ic_cbus2_max MAX @c4[i] from=0.00396 to=0.004
meas tran ic_cbus2_min MIN @c4[i] from=0.00396 to=0.004
meas tran ic_cout_rms RMS @cout[i] from=0.00396 to=0.004
meas tran ic_cout_max MAX @cout[i] from=0.00396 to=0.004
meas tran ic_cout_min MIN @cout[i] from=0.00396 to=0.004
quit
.endc
.end
