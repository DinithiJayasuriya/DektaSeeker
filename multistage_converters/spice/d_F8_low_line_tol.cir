* converter deck, bench.py (v90 48V->3V)
* corner=low_line_tol duty=0.1304
* device map (netlist -> deck): Sa0s1->S1, Sa1s1->S2, L0s1->L1, C0s1->C1, C1s1->C2, Sb0s1->S3, Sb0s2->S4, Sa1s2->S5, L0s2->L2
* nodes: IN->VIN, OUT->VOUT, 0->0, X->nX
Vin VIN 0 DC 43.2
Vpa PA 0 PULSE(0 1 0 1n 1n 2.608e-07 2e-06)
Vpb PB 0 PULSE(1 0 0 1n 1n 2.608e-07 2e-06)
.model SWMOD SW(ron=0.005 roff=1000000.0 vt=0.5 vh=0.01)
S1 0 ns1n10 PA 0 SWMOD
S2 nBUS1 ns1n9 PA 0 SWMOD
L1 VIN lx1 1.76e-06
RL1 lx1 ns1n9 0.004
C1 0 cx1 3.76e-05
RC1 cx1 nBUS1 0.002
C2 ns1n9 cx2 3.76e-05
RC2 cx2 ns1n10 0.002
S3 nBUS1 ns1n10 PB 0 SWMOD
S4 0 ns2n9 PB 0 SWMOD
S5 nBUS1 ns2n9 PA 0 SWMOD
L2 VOUT lx2 1.76e-06
RL2 lx2 ns2n9 0.004
Rout VOUT 0 0.3
Cout VOUT co_x 3.76e-05
RCo co_x 0 0.002
.options gmin=1e-12 reltol=1e-3 abstol=1e-9 vntol=1e-6 itl1=200 itl4=100
.control
set noaskquit
save all @c1[i] @c2[i] @cout[i]
tran 1e-08 0.004 0.00396 1e-08
let pout = v(VOUT)*v(VOUT)/0.3
let pin = -43.2*i(vin)
meas tran vout_avg AVG v(VOUT) from=0.00396 to=0.004
meas tran pout_avg AVG pout from=0.00396 to=0.004
meas tran pin_avg  AVG pin  from=0.00396 to=0.004
meas tran vout_max MAX v(VOUT) from=0.00396 to=0.004
meas tran vout_min MIN v(VOUT) from=0.00396 to=0.004
let vs1 = -v(ns1n10)
meas tran vs1_max MAX vs1 from=0.00396 to=0.004
meas tran vs1_min MIN vs1 from=0.00396 to=0.004
let vs2 = v(nBUS1)-v(ns1n9)
meas tran vs2_max MAX vs2 from=0.00396 to=0.004
meas tran vs2_min MIN vs2 from=0.00396 to=0.004
let vs3 = v(nBUS1)-v(ns1n10)
meas tran vs3_max MAX vs3 from=0.00396 to=0.004
meas tran vs3_min MIN vs3 from=0.00396 to=0.004
let vs4 = -v(ns2n9)
meas tran vs4_max MAX vs4 from=0.00396 to=0.004
meas tran vs4_min MIN vs4 from=0.00396 to=0.004
let vs5 = v(nBUS1)-v(ns2n9)
meas tran vs5_max MAX vs5 from=0.00396 to=0.004
meas tran vs5_min MIN vs5 from=0.00396 to=0.004
* --- capacitor current probes ---
meas tran ic_c0s1_rms RMS @c1[i] from=0.00396 to=0.004
meas tran ic_c0s1_max MAX @c1[i] from=0.00396 to=0.004
meas tran ic_c0s1_min MIN @c1[i] from=0.00396 to=0.004
meas tran ic_c1s1_rms RMS @c2[i] from=0.00396 to=0.004
meas tran ic_c1s1_max MAX @c2[i] from=0.00396 to=0.004
meas tran ic_c1s1_min MIN @c2[i] from=0.00396 to=0.004
meas tran ic_cout_rms RMS @cout[i] from=0.00396 to=0.004
meas tran ic_cout_max MAX @cout[i] from=0.00396 to=0.004
meas tran ic_cout_min MIN @cout[i] from=0.00396 to=0.004
quit
.endc
.end
